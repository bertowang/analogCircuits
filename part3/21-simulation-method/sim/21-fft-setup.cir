* Ch21 FFT setup: disable waveform compression
VIN in 0 SINE(0 1 1k)
R1 in out 1k
C1 out 0 100n
.tran 0 20m 0 2u
.four 1k V(out)
.options plotwinsize=0
.end
