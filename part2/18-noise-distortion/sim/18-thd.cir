* Ch18 THD of a hard-clipped sine via .four
VIN in 0 SINE(0 1 1k)
B1 out 0 V=max(-0.8,min(0.8,V(in)))
.tran 0 20m 0 2u
.four 1k V(out)
.options plotwinsize=0
.end
