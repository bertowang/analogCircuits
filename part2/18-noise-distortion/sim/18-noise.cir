* Ch18 Noise analysis of an RC + gain stage
VIN in 0 DC 0 AC 1
R1 in n1 1k
C1 n1 0 100n
E1 out 0 n1 0 10
.noise V(out) VIN dec 20 10 1Meg
.end
