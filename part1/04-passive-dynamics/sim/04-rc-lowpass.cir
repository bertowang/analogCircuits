* Ch04 RC low-pass: transfer function and -3dB point
V1 in 0 DC 0 AC 1
R1 in out 1k
C1 out 0 100n
.ac dec 30 10 100k
.meas AC g10 FIND mag(V(out)) AT 10
.meas AC g1k FIND mag(V(out)) AT 1k
.meas AC g10k FIND mag(V(out)) AT 10k
.end
