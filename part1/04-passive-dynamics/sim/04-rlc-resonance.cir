* Ch04 RLC series resonance (voltage across C)
V1 in 0 DC 0 AC 1
R1 in n1 10
L1 n1 out 10m
C1 out 0 100n
.ac dec 40 100 100k
.meas AC peak MAX mag(V(out))
.end
