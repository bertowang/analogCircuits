* Ch08 Open-loop opamp: virtual short does NOT hold
VIN in 0 DC 0 AC 1
E1 int 0 in 0 1e5
R1 int oa 1k
C1 oa 0 1u
.op
.ac dec 20 1 10Meg
.meas AC aol_1k FIND mag(V(oa)) AT 1k
.end
