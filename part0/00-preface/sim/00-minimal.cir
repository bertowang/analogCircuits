* Ch00 Minimal netlist: a voltage divider
V1 in 0 DC 5
R1 in out 3k
R2 out 0 2k
.op
.end
