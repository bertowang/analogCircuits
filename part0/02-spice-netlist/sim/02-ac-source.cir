* Ch02 AC source specification and a small-signal sweep
V1 in 0 DC 0 AC 1
R1 in out 1k
C1 out 0 100n
.ac dec 20 10 100k
.meas AC g10 FIND mag(V(out)) AT 10
.meas AC g1k FIND mag(V(out)) AT 1k
.end
